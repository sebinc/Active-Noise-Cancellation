| / 7\'7
| \ \   Xilinx Inc.
| / /
| \_\/.\   IBIS Models for SPARTAN-6
[IBIS ver]   4.2
[File name]   ANCTop_V.ibs
[File Rev]   1.3
[Date]   Wed August 08 20:08:23 2018
[Source]   Derived from spice models, rev0.21, using
   hspice 2007.12
[Notes]   Xilinx IBIS file for SPARTAN-6 I/O standards.
   All models are preliminary.
   The version of IBISCHK used is ibischk4.
   Ibis models were generated using S2IBIS3.
[Disclaimer] The data in this file is derived from SPICE simulations using
                 modeling information extracted from the target process. While
                 a great deal of care has been taken to provide information
                 that is accurate, this model is considered preliminary as it
                 has not been verified by actual silicon measurement. Treat the
                 data in this model as preliminary until actual silicon
                 verification is performed.
[Copyright]   Copyright 2009, 2010, Xilinx Inc., All rights reserved
|   Component SPARTAN-6
[Component]   SPARTAN-6
[Manufacturer]   Xilinx Inc.
[Package]
|CSG324
|variable   typ   min   max
R_pkg   115.02m   53.54m   220.96m
L_pkg   4.09nH   1.70nH   9.73nH
C_pkg   1.04pF   0.60pF   1.51pF
[Pin]  signal_name   model_name
P15   SPI_LED   LVCMOS33_F_8_LR_25
T4   SDI   LVCMOS33_S_12_TB_25
U7   SCK   LVCMOS33_S_12_TB_25
U5   SDO   LVCMOS33_F_8_TB_25
V10   Clk_100M   LVCMOS33_S_12_TB_25
M18   ResetSwitch   LVCMOS33_S_12_LR_25
B16   AudioL   LVCMOS33_F_8_TB_25
A16   AudioR   LVCMOS33_F_8_TB_25
D4   HSWAPEN   LVCMOS25_S_8_TB_25
C4   IO_L1N_VREF_0   NC
B2   IO_L2P_0   NC
A2   IO_L2N_0   NC
D6   IO_L3P_0   NC
C6   IO_L3N_0   NC
B3   IO_L4P_0   NC
A3   IO_L4N_0   NC
B4   IO_L5P_0   NC
A4   IO_L5N_0   NC
C5   IO_L6P_0   NC
A5   IO_L6N_0   NC
C7   IO_L10P_0   NC
A7   IO_L10N_0   NC
B6   IO_L8P_0   NC
A6   IO_L8N_VREF_0   NC
D8   IO_L11P_0   NC
C8   IO_L11N_0   NC
B8   IO_L33P_0   NC
A8   IO_L33N_0   NC
D9   GCLK19   NC
C9   GCLK18   NC
B9   GCLK17   NC
A9   GCLK16   NC
D11   GCLK15   NC
C11   GCLK14   NC
C10   GCLK13   NC
A10   GCLK12   NC
G9   IO_L38P_0   NC
F9   IO_L38N_VREF_0   NC
B11   IO_L39P_0   NC
A11   IO_L39N_0   NC
B12   IO_L41P_0   NC
A12   IO_L41N_0   NC
B14   IO_L62P_0   NC
A14   IO_L62N_VREF_0   NC
F13   SCP7   LVCMOS25_S_8_TB_25
E13   SCP6   LVCMOS25_S_8_TB_25
C15   SCP5   LVCMOS25_S_8_TB_25
A15   SCP4   LVCMOS25_S_8_TB_25
D14   SCP3   LVCMOS25_S_8_TB_25
C14   SCP2   LVCMOS25_S_8_TB_25
F15   A25   LVCMOS25_S_8_TB_25
F16   A24   LVCMOS25_S_8_TB_25
C17   A23_M1A13   NC
C18   A22_M1A14   NC
F14   A21_M1RESET   NC
G14   A20_M1A11   NC
D17   A19_M1CKE   NC
D18   A18_M1A12   NC
H12   A17_M1A8   NC
G13   A16_M1A9   NC
E16   A15_M1A10   NC
E18   A14_M1A4   NC
K12   A13_M1WE   NC
K13   A12_M1BA2   NC
F17   A11_M1A7   NC
F18   A10_M1A2   NC
H13   A9_M1BA0   NC
H14   A8_M1BA1   NC
H15   A7_M1A0   NC
H16   A6_M1A1   NC
G16   A5_M1CLK   NC
G18   A4_M1CLKN   NC
J13   M1A3   NC
K14   M1ODT   NC
L12   GCLK11_M1A5   NC
L13   GCLK10_M1A6   NC
K15   GCLK9_IRDY1_M1RASN   NC
K16   GCLK8_M1CASN   NC
L15   GCLK7_M1UDM   NC
L16   GCLK6_TRDY1_M1LDM   NC
H17   GCLK5_M1DQ4   NC
H18   GCLK4_M1DQ5   NC
J16   A3_M1DQ6   NC
J18   A2_M1DQ7   NC
K17   A1_M1LDQS   NC
K18   A0_M1LDQSN   NC
L17   FCS_B_M1DQ2   NC
L18   FOE_B_M1DQ3   NC
M16   FWE_B_M1DQ0   NC
N17   HDC_M1DQ8   NC
N18   M1DQ9   NC
P17   M1DQ10   NC
P18   M1DQ11   NC
N15   M1UDQS   NC
N16   M1UDQSN   NC
T17   M1DQ12   NC
T18   M1DQ13   NC
U17   M1DQ14   NC
U18   M1DQ15   NC
M14   IO_L53P_1   NC
N14   IO_L53N_VREF_1   NC
L14   IO_L61P_1   NC
M13   IO_L61N_1   NC
P16   DOUT_BUSY   LVCMOS25_S_8_TB_25
R15   CCLK   LVCMOS25_S_8_TB_25
T15   M0_CMPMISO   NC
U16   CMPCLK   NC
V16   CMPMOSI   NC
R13   D0_DIN_MISO_MISO1   LVCMOS25_S_8_TB_25
T13   MOSI_CSI_B_MISO0   LVCMOS25_S_8_TB_25
T14   D1_MISO2   LVCMOS25_S_8_TB_25
V14   D2_MISO3   LVCMOS25_S_8_TB_25
N12   M1   LVCMOS25_S_8_TB_25
P12   D10   LVCMOS25_S_8_TB_25
U13   D11   LVCMOS25_S_8_TB_25
V13   D12   LVCMOS25_S_8_TB_25
U11   IO_L23P_2   NC
V11   IO_L23N_2   NC
R11   IO_L16P_2   NC
T11   IO_L16N_VREF_2   NC
R10   GCLK3   NC
T10   GCLK2   NC
U10   GCLK1_D13   NC
R8   GCLK31_D14   NC
T8   GCLK30_D15   NC
T9   GCLK29   NC
V9   GCLK28   NC
T6   IO_L45P_2   NC
V6   IO_L45N_2   NC
U8   IO_L41P_2   NC
V8   IO_L41N_VREF_2   NC
V7   IO_L43N_2   NC
R7   IO_L46P_2   NC
T7   IO_L46N_2   NC
R5   D7   LVCMOS25_S_8_TB_25
T5   RDWR_B   LVCMOS25_S_8_TB_25
V5   D4   LVCMOS25_S_8_TB_25
R3   D5   LVCMOS25_S_8_TB_25
T3   D6   LVCMOS25_S_8_TB_25
V4   IO_L63N_2   NC
N5   D8   LVCMOS25_S_8_TB_25
P6   D9   LVCMOS25_S_8_TB_25
U3   INIT_B   LVCMOS25_S_8_TB_25
V3   CSO_B   LVCMOS25_S_8_TB_25
N4   IO_L1P_3   NC
N3   IO_L1N_VREF_3   NC
P4   IO_L2P_3   NC
P3   IO_L2N_3   NC
L6   IO_L31P_3   NC
M5   IO_L31N_VREF_3   NC
U2   M3DQ14   NC
U1   M3DQ15   NC
T2   M3DQ12   NC
T1   M3DQ13   NC
P2   M3UDQS   NC
P1   M3UDQSN   NC
N2   M3DQ10   NC
N1   M3DQ11   NC
M3   M3DQ8   NC
M1   M3DQ9   NC
L2   M3DQ0   NC
L1   M3DQ1   NC
K2   M3DQ2   NC
K1   M3DQ3   NC
L4   M3LDQS   NC
L3   M3LDQSN   NC
J3   M3DQ6   NC
J1   M3DQ7   NC
H2   GCLK27_M3DQ4   NC
H1   GCLK26_M3DQ5   NC
K4   GCLK25_TRDY2_M3UDM   NC
K3   GCLK24_M3LDM   NC
L5   GCLK23_M3RASN   NC
K5   GCLK22_IRDY2_M3CASN  NC
H4   GCLK21_M3A5   NC
H3   GCLK20_M3A6   NC
L7   M3A3   NC
K6   M3ODT   NC
G3   M3CLK   NC
G1   M3CLKN   NC
J7   M3A0   NC
J6   M3A1   NC
F2   M3BA0   NC
F1   M3BA1   NC
H6   M3A7   NC
H5   M3A2   NC
E3   M3WE   NC
E1   M3BA2   NC
F4   M3A10   NC
F3   M3A4   NC
D2   M3A8   NC
D1   M3A9   NC
H7   M3CKE   NC
G6   M3A12   NC
E4   M3RESET   NC
D3   M3A11   NC
F6   M3A13   NC
F5   M3A14   NC
C2   IO_L83P_3   NC
C1   IO_L83N_VREF_3   NC
A17   TCK   LVCMOS25_S_8_TB_25
D15   TDI   LVCMOS25_S_8_TB_25
B18   TMS   LVCMOS25_S_8_TB_25
D16   TDO   LVCMOS25_S_8_TB_25
R16   SUSPEND   LVCMOS25_S_8_TB_25
P13   CMPCS_B_2   NC
V17   DONE_2   LVCMOS25_S_8_TB_25
V2   PROGRAM_B_2   LVCMOS25_S_8_TB_25
A1   GND   GND
A18   GND   GND
B13   GND   GND
B7   GND   GND
C16   GND   GND
C3   GND   GND
D10   GND   GND
D5   GND   GND
E15   GND   GND
G12   GND   GND
G17   GND   GND
G2   GND   GND
G5   GND   GND
H10   GND   GND
H8   GND   GND
J11   GND   GND
J15   GND   GND
J4   GND   GND
J9   GND   GND
K10   GND   GND
K8   GND   GND
L11   GND   GND
L9   GND   GND
M17   GND   GND
M2   GND   GND
M6   GND   GND
N13   GND   GND
R1   GND   GND
R14   GND   GND
R18   GND   GND
R4   GND   GND
R9   GND   GND
T16   GND   GND
U12   GND   GND
U6   GND   GND
V1   GND   GND
V18   GND   GND
B10   VCCO_0   POWER
B15   VCCO_0   POWER
B5   VCCO_0   POWER
D13   VCCO_0   POWER
D7   VCCO_0   POWER
E10   VCCO_0   POWER
B1   VCCAUX   POWER
B17   VCCAUX   POWER
E14   VCCAUX   POWER
E5   VCCAUX   POWER
E9   VCCAUX   POWER
G10   VCCAUX   POWER
J12   VCCAUX   POWER
K7   VCCAUX   POWER
M9   VCCAUX   POWER
P10   VCCAUX   POWER
P14   VCCAUX   POWER
P5   VCCAUX   POWER
G7   VCCINT   POWER
H11   VCCINT   POWER
H9   VCCINT   POWER
J10   VCCINT   POWER
J8   VCCINT   POWER
K11   VCCINT   POWER
K9   VCCINT   POWER
L10   VCCINT   POWER
L8   VCCINT   POWER
M12   VCCINT   POWER
M7   VCCINT   POWER
E17   VCCO_1   POWER
G15   VCCO_1   POWER
J14   VCCO_1   POWER
J17   VCCO_1   POWER
M15   VCCO_1   POWER
R17   VCCO_1   POWER
P9   VCCO_2   POWER
R12   VCCO_2   POWER
R6   VCCO_2   POWER
U14   VCCO_2   POWER
U4   VCCO_2   POWER
U9   VCCO_2   POWER
E2   VCCO_3   POWER
G4   VCCO_3   POWER
J2   VCCO_3   POWER
J5   VCCO_3   POWER
M4   VCCO_3   POWER
R2   VCCO_3   POWER
[Package Model]   csg324_xc6slx9
[Diff Pin]   inv_Pin   vdiff   tdelay_typ   tdelay_min   tdelay_max
[Series Pin Mapping] pin_2   model_name   function_table_group
[Define Package Model]   csg324_xc6slx9
[Manufacturer]   Xilinx Inc.
[OEM]   Xilinx_S1
[Description]   214-pin Package
|[Number of Sections]   1
[Number of Pins]   214
[Pin Numbers]
|[Pin Name]  Net Number   Net Name   Net's All Pins
B1   | 1   VCCAUX   B1
   |B17
   |E14
   |E5
   |E9
   |G10
   |J12
   |K7
   |M9
   |P10
   |P14
   |P5
G7   | 2   VCCINT   G7
   |H11
   |H9
   |J10
   |J8
   |K11
   |K9
   |L10
   |L8
   |M12
   |M7
B10   | 3   VCCO_0   B10
   |B15
   |B5
   |D13
   |D7
   |E10
E17   | 4   VCCO_1   E17
   |G15
   |J14
   |J17
   |M15
   |R17
P9   | 5   VCCO_2   P9
   |R12
   |R6
   |U14
   |U4
   |U9
E2   | 6   VCCO_3   E2
   |G4
   |J2
   |J5
   |M4
   |R2
P13   | 7   CMP_CS_B_2   P13
V17   | 8   DONE_2   V17
A7   | 9   IO_L10N_0   A7
C7   | 10   IO_L10P_0   C7
C8   | 11   IO_L11N_0   C8
D8   | 12   IO_L11P_0   D8
V14   | 13   IO_L12N_D2_MISO3_2   V14
T14   | 14   IO_L12P_D1_MISO2_2   T14
P12   | 15   IO_L13N_D10_2   P12
N12   | 16   IO_L13P_M1_2   N12
V13   | 17   IO_L14N_D12_2   V13
U13   | 18   IO_L14P_D11_2   U13
T11   | 19   IO_L16N_VREF_2   T11
R11   | 20   IO_L16P_2   R11
F16   | 21   IO_L1N_A24_VREF_1   F16
C4   | 22   IO_L1N_IREF_VREF_0   C4
T15   | 23   IO_L1N_M0_CMPMISO_2   T15
N3   | 24   IO_L1N_VREF_3   N3
F15   | 25   IO_L1P_A25_1   F15
R15   | 26   IO_L1P_CCLK_2   R15
D4   | 27   IO_L1P_HSWAPEN_0   D4
N4   | 28   IO_L1P_VBG_3   N4
V11   | 29   IO_L23N_2   V11
U11   | 30   IO_L23P_2   U11
C18   | 31   IO_L29N_A22_M1A14_1   C18
T10   | 32   IO_L29N_GCLK2_2   T10
C17   | 33   IO_L29P_A23_M1A13_1   C17
R10   | 34   IO_L29P_GCLK3_2   R10
A2   | 35   IO_L2N_0   A2
V16   | 36   IO_L2N_CMPMOSI_2   V16
P3   | 37   IO_L2N_VTEMP_3   P3
B2   | 38   IO_L2P_0   B2
U16   | 39   IO_L2P_CMPCLK_2   U16
P4   | 40   IO_L2P_VGG_3   P4
G14   | 41   IO_L30N_A20_M1A11_1   G14
V10   | 42   IO_L30N_GCLK0_USERCCLK_2   V10
F14   | 43   IO_L30P_A21_M1RESET_1   F14
U10   | 44   IO_L30P_GCLK1_D13_2   U10
D18   | 45   IO_L31N_A18_M1A12_1   D18
T8   | 46   IO_L31N_GCLK30_D15_2   T8
M5   | 47   IO_L31N_VREF_3   M5
L6   | 48   IO_L31P_3   L6
D17   | 49   IO_L31P_A19_M1CKE_1   D17
R8   | 50   IO_L31P_GCLK31_D14_2   R8
G13   | 51   IO_L32N_A16_M1A9_1   G13
V9   | 52   IO_L32N_GCLK28_2   V9
U1   | 53   IO_L32N_M3DQ15_3   U1
H12   | 54   IO_L32P_A17_M1A8_1   H12
T9   | 55   IO_L32P_GCLK29_2   T9
U2   | 56   IO_L32P_M3DQ14_3   U2
A8   | 57   IO_L33N_0   A8
E18   | 58   IO_L33N_A14_M1A4_1   E18
T1   | 59   IO_L33N_M3DQ13_3   T1
B8   | 60   IO_L33P_0   B8
E16   | 61   IO_L33P_A15_M1A10_1   E16
T2   | 62   IO_L33P_M3DQ12_3   T2
K13   | 63   IO_L34N_A12_M1BA2_1   K13
C9   | 64   IO_L34N_GCLK18_0   C9
P1   | 65   IO_L34N_M3UDQSN_3   P1
K12   | 66   IO_L34P_A13_M1WE_1   K12
D9   | 67   IO_L34P_GCLK19_0   D9
P2   | 68   IO_L34P_M3UDQS_3   P2
F18   | 69   IO_L35N_A10_M1A2_1   F18
A9   | 70   IO_L35N_GCLK16_0   A9
N1   | 71   IO_L35N_M3DQ11_3   N1
F17   | 72   IO_L35P_A11_M1A7_1   F17
B9   | 73   IO_L35P_GCLK17_0   B9
N2   | 74   IO_L35P_M3DQ10_3   N2
H14   | 75   IO_L36N_A8_M1BA1_1   H14
C11   | 76   IO_L36N_GCLK14_0   C11
M1   | 77   IO_L36N_M3DQ9_3   M1
H13   | 78   IO_L36P_A9_M1BA0_1   H13
D11   | 79   IO_L36P_GCLK15_0   D11
M3   | 80   IO_L36P_M3DQ8_3   M3
H16   | 81   IO_L37N_A6_M1A1_1   H16
A10   | 82   IO_L37N_GCLK12_0   A10
L1   | 83   IO_L37N_M3DQ1_3   L1
H15   | 84   IO_L37P_A7_M1A0_1   H15
C10   | 85   IO_L37P_GCLK13_0   C10
L2   | 86   IO_L37P_M3DQ0_3   L2
G18   | 87   IO_L38N_A4_M1CLKN_1   G18
K1   | 88   IO_L38N_M3DQ3_3   K1
F9   | 89   IO_L38N_VREF_0   F9
G9   | 90   IO_L38P_0   G9
G16   | 91   IO_L38P_A5_M1CLK_1   G16
K2   | 92   IO_L38P_M3DQ2_3   K2
A11   | 93   IO_L39N_0   A11
K14   | 94   IO_L39N_M1ODT_1   K14
L3   | 95   IO_L39N_M3LDQSN_3   L3
B11   | 96   IO_L39P_0   B11
J13   | 97   IO_L39P_M1A3_1   J13
L4   | 98   IO_L39P_M3LDQS_3   L4
C6   | 99   IO_L3N_0   C6
T13   | 100   IO_L3N_MOSI_CSI_B_MISO0_2   T13
D6   | 101   IO_L3P_0   D6
R13   | 102   IO_L3P_D0_DIN_MISO_MISO1_2   R13
L13   | 103   IO_L40N_GCLK10_M1A6_1   L13
J1   | 104   IO_L40N_M3DQ7_3   J1
L12   | 105   IO_L40P_GCLK11_M1A5_1   L12
J3   | 106   IO_L40P_M3DQ6_3   J3
A12   | 107   IO_L41N_0   A12
H1   | 108   IO_L41N_GCLK26_M3DQ5_3   H1
K16   | 109   IO_L41N_GCLK8_M1CASN_1   K16
V8   | 110   IO_L41N_VREF_2   V8
B12   | 111   IO_L41P_0   B12
U8   | 112   IO_L41P_2   U8
H2   | 113   IO_L41P_GCLK27_M3DQ4_3   H2
K15   | 114   IO_L41P_GCLK9_IRDY1_M1RASN_1   K15
K3   | 115   IO_L42N_GCLK24_M3LDM_3   K3
L16   | 116   IO_L42N_GCLK6_TRDY1_M1LDM_1   L16
K4   | 117   IO_L42P_GCLK25_TRDY2_M3UDM_3   K4
L15   | 118   IO_L42P_GCLK7_M1UDM_1   L15
V7   | 119   IO_L43N_2   V7
K5   | 120   IO_L43N_GCLK22_IRDY2_M3CASN_3   K5
H18   | 121   IO_L43N_GCLK4_M1DQ5_1   H18
U7   | 122   IO_L43P_2   U7
L5   | 123   IO_L43P_GCLK23_M3RASN_3   L5
H17   | 124   IO_L43P_GCLK5_M1DQ4_1   H17
J18   | 125   IO_L44N_A2_M1DQ7_1   J18
H3   | 126   IO_L44N_GCLK20_M3A6_3   H3
J16   | 127   IO_L44P_A3_M1DQ6_1   J16
H4   | 128   IO_L44P_GCLK21_M3A5_3   H4
V6   | 129   IO_L45N_2   V6
K18   | 130   IO_L45N_A0_M1LDQSN_1   K18
K6   | 131   IO_L45N_M3ODT_3   K6
T6   | 132   IO_L45P_2   T6
K17   | 133   IO_L45P_A1_M1LDQS_1   K17
L7   | 134   IO_L45P_M3A3_3   L7
T7   | 135   IO_L46N_2   T7
L18   | 136   IO_L46N_FOE_B_M1DQ3_1   L18
G1   | 137   IO_L46N_M3CLKN_3   G1
R7   | 138   IO_L46P_2   R7
L17   | 139   IO_L46P_FCS_B_M1DQ2_1   L17
G3   | 140   IO_L46P_M3CLK_3   G3
M18   | 141   IO_L47N_LDC_M1DQ1_1   M18
J6   | 142   IO_L47N_M3A1_3   J6
M16   | 143   IO_L47P_FWE_B_M1DQ0_1   M16
J7   | 144   IO_L47P_M3A0_3   J7
N18   | 145   IO_L48N_M1DQ9_1   N18
F1   | 146   IO_L48N_M3BA1_3   F1
T5   | 147   IO_L48N_RDWR_B_VREF_2   T5
R5   | 148   IO_L48P_D7_2   R5
N17   | 149   IO_L48P_HDC_M1DQ8_1   N17
F2   | 150   IO_L48P_M3BA0_3   F2
V5   | 151   IO_L49N_D4_2   V5
P18   | 152   IO_L49N_M1DQ11_1   P18
H5   | 153   IO_L49N_M3A2_3   H5
U5   | 154   IO_L49P_D3_2   U5
P17   | 155   IO_L49P_M1DQ10_1   P17
H6   | 156   IO_L49P_M3A7_3   H6
A3   | 157   IO_L4N_0   A3
B3   | 158   IO_L4P_0   B3
N16   | 159   IO_L50N_M1UDQSN_1   N16
E1   | 160   IO_L50N_M3BA2_3   E1
N15   | 161   IO_L50P_M1UDQS_1   N15
E3   | 162   IO_L50P_M3WE_3   E3
T18   | 163   IO_L51N_M1DQ13_1   T18
F3   | 164   IO_L51N_M3A4_3   F3
T17   | 165   IO_L51P_M1DQ12_1   T17
F4   | 166   IO_L51P_M3A10_3   F4
U18   | 167   IO_L52N_M1DQ15_1   U18
D1   | 168   IO_L52N_M3A9_3   D1
U17   | 169   IO_L52P_M1DQ14_1   U17
D2   | 170   IO_L52P_M3A8_3   D2
G6   | 171   IO_L53N_M3A12_3   G6
N14   | 172   IO_L53N_VREF_1   N14
M14   | 173   IO_L53P_1   M14
H7   | 174   IO_L53P_M3CKE_3   H7
D3   | 175   IO_L54N_M3A11_3   D3
E4   | 176   IO_L54P_M3RESET_3   E4
F5   | 177   IO_L55N_M3A14_3   F5
F6   | 178   IO_L55P_M3A13_3   F6
A4   | 179   IO_L5N_0   A4
B4   | 180   IO_L5P_0   B4
M13   | 181   IO_L61N_1   M13
L14   | 182   IO_L61P_1   L14
T3   | 183   IO_L62N_D6_2   T3
A14   | 184   IO_L62N_VREF_0   A14
B14   | 185   IO_L62P_0   B14
R3   | 186   IO_L62P_D5_2   R3
V4   | 187   IO_L63N_2   V4
E13   | 188   IO_L63N_SCP6_0   E13
T4   | 189   IO_L63P_2   T4
F13   | 190   IO_L63P_SCP7_0   F13
P6   | 191   IO_L64N_D9_2   P6
A15   | 192   IO_L64N_SCP4_0   A15
N5   | 193   IO_L64P_D8_2   N5
C15   | 194   IO_L64P_SCP5_0   C15
V3   | 195   IO_L65N_CSO_B_2   V3
C14   | 196   IO_L65N_SCP2_0   C14
U3   | 197   IO_L65P_INIT_B_2   U3
D14   | 198   IO_L65P_SCP3_0   D14
A16   | 199   IO_L66N_SCP0_0   A16
B16   | 200   IO_L66P_SCP1_0   B16
A5   | 201   IO_L6N_0   A5
C5   | 202   IO_L6P_0   C5
P16   | 203   IO_L74N_DOUT_BUSY_1   P16
P15   | 204   IO_L74P_AWAKE_1   P15
C1   | 205   IO_L83N_VREF_3   C1
C2   | 206   IO_L83P_3   C2
A6   | 207   IO_L8N_VREF_0   A6
B6   | 208   IO_L8P_0   B6
V2   | 209   PROGRAM_B   V2
R16   | 210   SUSPEND   R16
A17   | 211   TCK   A17
D15   | 212   TDI   D15
D16   | 213   TDO   D16
B18   | 214   TMS   B18
[Model Data]
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[End Model Data]
[End Package Model]
| Models and submodels in the file (5): LVCMOS25_S_8_TB_25 (I/O), LVCMOS33_F_8_LR_25 (I/O), LVCMOS33_F_8_TB_25 (I/O), LVCMOS33_S_12_LR_25 (I/O), LVCMOS33_S_12_TB_25 (I/O)
